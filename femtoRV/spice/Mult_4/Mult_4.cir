* VDD Level: 3.3V
* Signals: 4

.lib /usr/local/share/pdk/sky130A/libs.tech/ngspice/sky130.lib.spice tt
.tran 10000ns 200us
.print tran format=raw file=Mult4_cir.raw  v(*)
* Fuentes de alimentación
Vvdd VPWR 0 DC 3.3
Vgnd VGND 0 DC 0
* clk - 100 transitions
V_clk clk 0 PWL(0 0 9.99999999e-06 0 9.999999999999999e-06 3.3 1.999999999e-05 3.3 1.9999999999999998e-05 0 2.999999999e-05 0 3e-05 3.3 3.999999998999999e-05 3.3 3.9999999999999996e-05 0 4.999999998999999e-05 0 4.9999999999999996e-05 3.3 5.999999999e-05 3.3 6e-05 0 6.999999998999999e-05 0 7e-05 3.3 7.999999998999999e-05 3.3 7.999999999999999e-05 0 8.999999998999999e-05 0 8.999999999999999e-05 3.3 9.999999998999999e-05 3.3 9.999999999999999e-05 0 0.00010999999999 0 0.00011 3.3 0.00011999999999 3.3 0.00012 0 0.00012999999998999999 0 0.00013 3.3 0.00013999999998999998 3.3 0.00014 0 0.00014999999998999998 0 0.00015 3.3 0.00015999999998999998 3.3 0.00015999999999999999 0 0.00016999999998999998 0 0.00016999999999999999 3.3 0.00017999999998999998 3.3 0.00017999999999999998 0 0.00018999999998999998 0 0.00018999999999999998 3.3 0.00019999999998999998 3.3 0.00019999999999999998 0 0.00020999999999 0 0.00021 3.3 0.00021999999999 3.3 0.00022 0 0.00022999999999 0 0.00023 3.3 0.00023999999999 3.3 0.00024 0 0.00024999999999000003 0 0.00025 3.3 0.00025999999999 3.3 0.00026 0 0.00026999999999000003 0 0.00027 3.3 0.00027999999999 3.3 0.00028 0 0.00028999999999 0 0.00029 3.3 0.00029999999999 3.3 0.0003 0 0.00030999999999 0 0.00031 3.3 0.00031999999999 3.3 0.00031999999999999997 0 0.00032999999999 0 0.00033 3.3 0.00033999999999 3.3 0.00033999999999999997 0 0.00034999999999 0 0.00035 3.3 0.00035999999999 3.3 0.00035999999999999997 0 0.00036999999999 0 0.00037 3.3 0.00037999999999 3.3 0.00037999999999999997 0 0.00038999999999 0 0.00039 3.3 0.00039999999999 3.3 0.00039999999999999996 0 0.00040999999999 0 0.00041 3.3 0.00041999999999000004 3.3 0.00042 0 0.00042999999999 0 0.00043 3.3 0.00043999999999000004 3.3 0.00044 0 0.00044999999999 0 0.00045 3.3 0.00045999999999000004 3.3 0.00046 0 0.00046999999999 0 0.00047 3.3 0.00047999999999000004 3.3 0.00048 0 0.00048999999999 0 0.00049 3.3 0.00049999999999 3.3 0.0005 0 0.00050999999999 0 0.00051 3.3 0.0005199999999899999 3.3 0.00052 0 0.00052999999999 0 0.00053 3.3 0.00053999999999 3.3 0.00054 0 0.00054999999999 0 0.00055 3.3 0.0005599999999899999 3.3 0.00056 0 0.00056999999999 0 0.00057 3.3 0.00057999999999 3.3 0.00058 0 0.00058999999999 0 0.00059 3.3 0.0005999999999899999 3.3 0.0006 0 0.0006099999999899999 0 0.00061 3.3 0.00061999999999 3.3 0.00062 0 0.00062999999999 0 0.00063 3.3 0.0006399999999899999 3.3 0.0006399999999999999 0 0.0006499999999899999 0 0.00065 3.3 0.00065999999999 3.3 0.00066 0 0.00066999999999 0 0.00067 3.3 0.0006799999999899999 3.3 0.0006799999999999999 0 0.0006899999999899999 0 0.00069 3.3 0.00069999999999 3.3 0.0007 0 0.00070999999999 0 0.00071 3.3 0.0007199999999899999 3.3 0.0007199999999999999 0 0.0007299999999899999 0 0.00073 3.3 0.00073999999999 3.3 0.00074 0 0.00074999999999 0 0.00075 3.3 0.0007599999999899999 3.3 0.0007599999999999999 0 0.0007699999999899999 0 0.00077 3.3 0.00077999999999 3.3 0.00078 0 0.00078999999999 0 0.00079 3.3 0.0007999999999899999 3.3 0.0007999999999999999 0 0.0008099999999899999 0 0.00081 3.3 0.00081999999999 3.3 0.00082 0 0.00082999999999 0 0.00083 3.3 0.00083999999999 3.3 0.00084 0 0.0008499999999899999 0 0.00085 3.3 0.00085999999999 3.3 0.00086 0 0.00086999999999 0 0.00087 3.3 0.00087999999999 3.3 0.00088 0 0.0008899999999899999 0 0.00089 3.3 0.0008999999999899999 3.3 0.0009 0 0.00090999999999 0 0.00091 3.3 0.00091999999999 3.3 0.00092 0 0.0009299999999899999 0 0.0009299999999999999 3.3 0.0009399999999899999 3.3 0.00094 0 0.00094999999999 0 0.00095 3.3 0.00095999999999 3.3 0.00096 0 0.0009699999999899999 0 0.0009699999999999999 3.3 0.00097999999999 3.3 0.00098 0 0.00098999999999 0 0.00099 3.3 0.00099999999999 3.3 0.001 0)

* init - 2 transitions
V_init init 0 PWL(0 0 0.00012999999998999999 0 0.00013 3.3 0.00016999999998999998 3.3 0.00016999999999999999 0)

* reset - 2 transitions
V_reset reset 0 PWL(0 0 1.999999999e-05 0 1.9999999999999998e-05 3.3 3.999999998999999e-05 3.3 3.9999999999999996e-05 0)

* SPICE3 file created from Mult_4.ext - technology: sky130A
VA0 A[0]   0 dc 0
VA1 A[1]   0 dc 3.3
VA2 A[2]   0 dc 0
VA3 A[3]   0 dc 3.3
VA4 A[4]   0 dc 0
VA5 A[5]   0 dc 0
VA6 A[6]   0 dc 0
VA7 A[7]   0 dc 0

VB0 B[0]   0 dc 0
VB1 B[1]   0 dc 3.3
VB2 B[2]   0 dc 0
VB3 B[3]   0 dc 3.3

.include "./Mult_4.spice"
.end
